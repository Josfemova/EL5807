// Verilog-AMS netlist generated by the AMS netlister, version  IC6.1.7-64b.500.23 .
// Cadence Design Systems, Inc.

`include "disciplines.vams"

(* cds_ams_schematic *)
module FAHDLLX0 ( CI,A,CO,B,.gnd(\gnd! ),S,.
vdd(\vdd! ) );

input   CI;
input   A;
output   CO;
input   B;
inout  (*
integer
inh_conn_prop_name = "ground_gnd";
integer inh_conn_def_value
 = "cds_globals.\\gnd! ";
 *)
 \gnd! ;
output   S;
inout  (*
integer
inh_conn_prop_name = "power_vdd";
integer inh_conn_def_value
 = "cds_globals.\\vdd! ";
 *)
 \vdd! ;

ne #(.m(1 * 1), .ad(2.016E-13), .nrd(0.642857), .w(420.0n), .pd(1.8E-06),
 .par1((1 * 1)), .as(2.016E-13), .nrs(0.642857), .ps(1.8E-06), .l(210.0n))
(*
integer library_binding = "PRIMLIB";
integer passed_mfactor = "m";

 *)
M8 ( net175, A, \gnd! , \gnd!  );
ne #(.m(1 * 1), .ad(2.016E-13), .nrd(0.642857), .w(420.0n), .pd(1.8E-06),
 .par1((1 * 1)), .as(2.016E-13), .nrs(0.642857), .ps(1.8E-06), .l(210.0n))
(*
integer library_binding = "PRIMLIB";
integer passed_mfactor = "m";

 *)
M10 ( net179, A, \gnd! , \gnd!  );
ne #(.m(1 * 1), .ad(2.016E-13), .nrd(0.642857), .w(420.0n), .pd(1.8E-06),
 .par1((1 * 1)), .as(2.016E-13), .nrs(0.642857), .ps(1.8E-06), .l(210.0n))
(*
integer library_binding = "PRIMLIB";
integer passed_mfactor = "m";

 *)
M6 ( net175, CI, \gnd! , \gnd!  );
ne #(.m(1 * 1), .ad(2.016E-13), .nrd(0.642857), .w(420.0n), .pd(1.8E-06),
 .par1((1 * 1)), .as(2.016E-13), .nrs(0.642857), .ps(1.8E-06), .l(210.0n))
(*
integer library_binding = "PRIMLIB";
integer passed_mfactor = "m";

 *)
M11 ( net171, B, net179, \gnd!  );
ne #(.m(1 * 1), .ad(2.016E-13), .nrd(0.642857), .pd(1.8E-06), .w(420.0n),
 .par1((1 * 1)), .as(2.016E-13), .nrs(0.642857), .ps(1.8E-06), .l(210.0n))
(*
integer library_binding = "PRIMLIB";
integer passed_mfactor = "m";

 *)
M1 ( net167, B, net151, \gnd!  );
ne #(.m(1 * 1), .ad(2.016E-13), .nrd(0.642857), .pd(1.8E-06), .w(420.0n),
 .par1((1 * 1)), .as(2.016E-13), .nrs(0.642857), .ps(1.8E-06), .l(210.0n))
(*
integer library_binding = "PRIMLIB";
integer passed_mfactor = "m";

 *)
M4 ( net163, A, \gnd! , \gnd!  );
ne #(.m(1 * 1), .ad(2.016E-13), .nrd(0.642857), .w(420.0n), .pd(1.8E-06),
 .par1((1 * 1)), .as(2.016E-13), .nrs(0.642857), .ps(1.8E-06), .l(210.0n))
(*
integer library_binding = "PRIMLIB";
integer passed_mfactor = "m";

 *)
M9 ( net159, net167, net175, \gnd!  );
ne #(.m(1 * 1), .ad(2.016E-13), .nrd(0.642857), .pd(1.8E-06), .w(420.0n),
 .par1((1 * 1)), .as(2.016E-13), .nrs(0.642857), .ps(1.8E-06), .l(210.0n))
(*
integer library_binding = "PRIMLIB";
integer passed_mfactor = "m";

 *)
M3 ( net167, CI, net163, \gnd!  );
ne #(.m(1 * 1), .ad(2.016E-13), .nrd(0.642857), .pd(1.8E-06), .w(420.0n),
 .par1((1 * 1)), .as(2.016E-13), .nrs(0.642857), .ps(1.8E-06), .l(210.0n))
(*
integer library_binding = "PRIMLIB";
integer passed_mfactor = "m";

 *)
M2 ( net151, A, \gnd! , \gnd!  );
ne #(.m(1 * 1), .ad(2.016E-13), .nrd(0.642857), .pd(1.8E-06), .w(420.0n),
 .par1((1 * 1)), .as(2.016E-13), .nrs(0.642857), .ps(1.8E-06), .l(210.0n))
(*
integer library_binding = "PRIMLIB";
integer passed_mfactor = "m";

 *)
M12 ( net159, CI, net171, \gnd!  );
ne #(.m(1 * 1), .ad(2.016E-13), .nrd(0.642857), .w(420.0n), .pd(1.8E-06),
 .par1((1 * 1)), .as(2.016E-13), .nrs(0.642857), .ps(1.8E-06), .l(210.0n))
(*
integer library_binding = "PRIMLIB";
integer passed_mfactor = "m";

 *)
M7 ( net175, B, \gnd! , \gnd!  );
ne #(.m(1 * 1), .ad(2.016E-13), .nrd(0.642857), .pd(1.8E-06), .w(420.0n),
 .par1((1 * 1)), .as(2.016E-13), .nrs(0.642857), .ps(1.8E-06), .l(210.0n))
(*
integer library_binding = "PRIMLIB";
integer passed_mfactor = "m";

 *)
M5 ( net163, B, \gnd! , \gnd!  );

pe #(.m(1 * 1), .ad(3.36E-13), .nrd(0.385714), .pd(2.36E-06), .w(700n),
 .par1((1 * 1)), .as(3.36E-13), .nrs(0.385714), .ps(2.36E-06), .l(210.0n))
(*
integer library_binding = "PRIMLIB";
integer passed_mfactor = "m";

 *)
M19 ( net167, CI, net99, \vdd!  );
pe #(.m(1 * 1), .ad(3.36E-13), .nrd(0.385714), .w(700n), .pd(2.36E-06),
 .par1((1 * 1)), .as(3.36E-13), .nrs(0.385714), .ps(2.36E-06), .l(210.0n))
(*
integer library_binding = "PRIMLIB";
integer passed_mfactor = "m";

 *)
M27 ( net125, A, \vdd! , \vdd!  );
pe #(.m(1 * 1), .ad(3.36E-13), .nrd(0.385714), .w(700n), .pd(2.36E-06),
 .par1((1 * 1)), .as(3.36E-13), .nrs(0.385714), .ps(2.36E-06), .l(210.0n))
(*
integer library_binding = "PRIMLIB";
integer passed_mfactor = "m";

 *)
M26 ( net159, CI, net129, \vdd!  );
pe #(.m(1 * 1), .ad(3.36E-13), .nrd(0.385714), .w(700n), .pd(2.36E-06),
 .par1((1 * 1)), .as(3.36E-13), .nrs(0.385714), .ps(2.36E-06), .l(210.0n))
(*
integer library_binding = "PRIMLIB";
integer passed_mfactor = "m";

 *)
M25 ( net129, B, net125, \vdd!  );
pe #(.m(1 * 1), .ad(2.784E-13), .nrd(0.465517), .w(580.0n), .pd(2.12E-06),
 .par1((1 * 1)), .as(2.784E-13), .nrs(0.465517), .ps(2.12E-06), .l(210.0n))
(*
integer library_binding = "PRIMLIB";
integer passed_mfactor = "m";

 *)
M24 ( net159, net167, net107, \vdd!  );
pe #(.m(1 * 1), .ad(3.36E-13), .nrd(0.385714), .w(700n), .pd(2.36E-06),
 .par1((1 * 1)), .as(3.36E-13), .nrs(0.385714), .ps(2.36E-06), .l(210.0n))
(*
integer library_binding = "PRIMLIB";
integer passed_mfactor = "m";

 *)
M23 ( net107, B, \vdd! , \vdd!  );
pe #(.m(1 * 1), .ad(3.36E-13), .nrd(0.385714), .w(700n), .pd(2.36E-06),
 .par1((1 * 1)), .as(3.36E-13), .nrs(0.385714), .ps(2.36E-06), .l(210.0n))
(*
integer library_binding = "PRIMLIB";
integer passed_mfactor = "m";

 *)
M22 ( net107, A, \vdd! , \vdd!  );
pe #(.m(1 * 1), .ad(3.36E-13), .nrd(0.385714), .w(700n), .pd(2.36E-06),
 .par1((1 * 1)), .as(3.36E-13), .nrs(0.385714), .ps(2.36E-06), .l(210.0n))
(*
integer library_binding = "PRIMLIB";
integer passed_mfactor = "m";

 *)
M21 ( net107, CI, \vdd! , \vdd!  );
pe #(.m(1 * 1), .ad(3.36E-13), .nrd(0.385714), .w(700n), .pd(2.36E-06),
 .par1((1 * 1)), .as(3.36E-13), .nrs(0.385714), .ps(2.36E-06), .l(210.0n))
(*
integer library_binding = "PRIMLIB";
integer passed_mfactor = "m";

 *)
M20 ( net99, B, \vdd! , \vdd!  );
pe #(.m(1 * 1), .ad(3.36E-13), .nrd(0.385714), .w(700n), .pd(2.36E-06),
 .par1((1 * 1)), .as(3.36E-13), .nrs(0.385714), .ps(2.36E-06), .l(210.0n))
(*
integer library_binding = "PRIMLIB";
integer passed_mfactor = "m";

 *)
M18 ( net99, A, \vdd! , \vdd!  );
pe #(.m(1 * 1), .ad(3.36E-13), .nrd(0.385714), .w(700n), .pd(2.36E-06),
 .par1((1 * 1)), .as(3.36E-13), .nrs(0.385714), .ps(2.36E-06), .l(210.0n))
(*
integer library_binding = "PRIMLIB";
integer passed_mfactor = "m";

 *)
M17 ( net167, B, net97, \vdd!  );
pe #(.m(1 * 1), .ad(3.36E-13), .nrd(0.385714), .w(700n), .pd(2.36E-06),
 .par1((1 * 1)), .as(3.36E-13), .nrs(0.385714), .ps(2.36E-06), .l(210.0n))
(*
integer library_binding = "PRIMLIB";
integer passed_mfactor = "m";

 *)
M16 ( net97, A, \vdd! , \vdd!  );

invr #(.lc(2.7e-07), .GT_PDW(420.00n), .sx(4.8e-07), .GT_PDL(210.00n),
 .GT_PUW(700.0n), .GT_PUL(210.00n)) (*
integer library_binding
 = "GATES_HD";
 *)
invr_2 ( .in( net159 ), .out( S ) );
invr #(.lc(2.7e-07), .GT_PDW(420.00n), .sx(4.8e-07), .GT_PDL(210.00n),
 .GT_PUW(700.0n), .GT_PUL(210.00n)) (*
integer library_binding
 = "GATES_HD";
 *)
invr_1 ( .in( net167 ), .out( CO ) );

endmodule
