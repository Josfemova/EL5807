// Verilog-AMS netlist generated by the AMS netlister, version  IC6.1.7-64b.500.23 .
// Cadence Design Systems, Inc.

`include "disciplines.vams"

(* cds_ams_schematic *)
module EO2HDLLX0 ( A,B,.gnd(\gnd! ),Q,.vdd(
\vdd! ) );

input   A;
input   B;
inout  (*
integer inh_conn_prop_name
 = "ground_gnd";
integer inh_conn_def_value = "cds_globals.\\gnd! ";

 *)
 \gnd! ;
output   Q;
inout  (*
integer inh_conn_prop_name
 = "power_vdd";
integer inh_conn_def_value = "cds_globals.\\vdd! ";

 *)
 \vdd! ;

a2no2_0 #(.lc(2.7e-07), .GT_PDW(420.00n), .sx(4.8e-07), .GT_PDL(210.00n),
 .GT_PUW(720.00n), .GT_PUL(210.00n)) (*
integer library_binding
 = "GATES_HD";
 *)
a2no2_1 ( .out( Q ), .a( A ), .c( net10 ), .b( B ) );

nor2 #(.lc(2.7e-07), .GT_PDW(420.00n), .sx(4.8e-07), .GT_PDL(210.00n),
 .GT_PUW(720.00n), .GT_PUL(210.00n)) (*
integer library_binding
 = "GATES_HD";
 *)
nor2_1 ( .out( net10 ), .a( A ), .b( B ) );

endmodule
