//Verilog-AMS HDL for "D_CELLS_HDLL", "AND2HDLLX0" "verilogams"

`include "constants.vams"
`include "disciplines.vams"

// Created by ihdl
`timescale 1ns/10ps

`celldefine

module AND2HDLLX0 (A, B, Q);
//*****************************************************************
//   technology       : 180 nm HV SOI CMOS
//   module name      : AND2HDLLX0
//   version          : 1.3.0, Tue Apr 28 06:15:00 2020
//   cell_description : 2-Input AND
//   last modified by : XLIB_PROC generated
//****************************************************************************
input (* integer supplySensitivity="\\vdd! "; integer groundSensitivity="\\gnd! "; *) A, B;
output (* integer supplySensitivity="\\vdd! "; integer groundSensitivity="\\gnd! "; *) Q;
electrical (* integer inh_conn_prop_name="ground_gnd"; integer inh_conn_def_value="cds_globals.\\gnd! "; *) \gnd! ;
electrical (* integer inh_conn_prop_name="power_vdd"; integer inh_conn_def_value="cds_globals.\\vdd! "; *) \vdd! ;

// logic section:

// Function Q: (A*B)
	and	i0 (Q, A, B);

// timing section:
   specify
      (A +=> Q) = (0.02, 0.02);
      (B +=> Q) = (0.02, 0.02);
   endspecify

endmodule

`endcelldefine
